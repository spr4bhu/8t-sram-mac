simulator lang=spectre
ic XB0.XC0.Q=0 XB0.XC0.Qbar=1.8
ic XB0.XC1.Q=0 XB0.XC1.Qbar=1.8
ic XB0.XC2.Q=0 XB0.XC2.Qbar=1.8
ic XB0.XC3.Q=0 XB0.XC3.Qbar=1.8
ic XB0.XC4.Q=1.8 XB0.XC4.Qbar=0
ic XB0.XC5.Q=1.8 XB0.XC5.Qbar=0
ic XB0.XC6.Q=1.8 XB0.XC6.Qbar=0
ic XB0.XC7.Q=1.8 XB0.XC7.Qbar=0
ic XB1.XC0.Q=0 XB1.XC0.Qbar=1.8
ic XB1.XC1.Q=0 XB1.XC1.Qbar=1.8
ic XB1.XC2.Q=0 XB1.XC2.Qbar=1.8
ic XB1.XC3.Q=0 XB1.XC3.Qbar=1.8
ic XB1.XC4.Q=1.8 XB1.XC4.Qbar=0
ic XB1.XC5.Q=1.8 XB1.XC5.Qbar=0
ic XB1.XC6.Q=1.8 XB1.XC6.Qbar=0
ic XB1.XC7.Q=1.8 XB1.XC7.Qbar=0
ic XB2.XC0.Q=0 XB2.XC0.Qbar=1.8
ic XB2.XC1.Q=0 XB2.XC1.Qbar=1.8
ic XB2.XC2.Q=0 XB2.XC2.Qbar=1.8
ic XB2.XC3.Q=0 XB2.XC3.Qbar=1.8
ic XB2.XC4.Q=1.8 XB2.XC4.Qbar=0
ic XB2.XC5.Q=1.8 XB2.XC5.Qbar=0
ic XB2.XC6.Q=1.8 XB2.XC6.Qbar=0
ic XB2.XC7.Q=1.8 XB2.XC7.Qbar=0
ic XB3.XC0.Q=0 XB3.XC0.Qbar=1.8
ic XB3.XC1.Q=0 XB3.XC1.Qbar=1.8
ic XB3.XC2.Q=0 XB3.XC2.Qbar=1.8
ic XB3.XC3.Q=0 XB3.XC3.Qbar=1.8
ic XB3.XC4.Q=1.8 XB3.XC4.Qbar=0
ic XB3.XC5.Q=1.8 XB3.XC5.Qbar=0
ic XB3.XC6.Q=1.8 XB3.XC6.Qbar=0
ic XB3.XC7.Q=1.8 XB3.XC7.Qbar=0
