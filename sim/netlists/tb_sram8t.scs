include "sram8t.scs"
V5 (PRE 0) vsource type=pulse val0=1.8 val1=0 period=20n delay=9n \
        rise=100p fall=100p width=2.5n
V3 (RWL 0) vsource type=pulse val0=0 val1=1.8 period=20n delay=12n \
        rise=100p fall=100p width=4n
V2 (WWL 0) vsource type=pulse val0=0 val1=1.8 period=20n delay=5n \
        rise=100p fall=100p width=3n
V1 (BLB 0) vsource type=pulse val0=1.8 val1=0 period=40n delay=4n \
        rise=100p fall=100p width=5n
V0 (BL 0) vsource type=pulse val0=1.8 val1=0 period=40n delay=24n \
        rise=100p fall=100p width=5n
C2 (RBL 0) capacitor c=100f
V4 (VDD 0) vsource dc=1.8 type=dc
PM0 (VDD PRE RBL VDD) pmos1 w=(2u) l=180n as=1.2p ad=1.2p ps=5.2u pd=5.2u \
        m=(1)*(1)
I0 (BL BLB 0 RBL RWL VDD WWL) sram8t
simulatorOptions options reltol=1e-3 vabstol=1e-6 iabstol=1e-12 temp=27 \
    tnom=27 scalem=1.0 scale=1.0 gmin=1e-12 rforce=1 maxnotes=5 maxwarns=5 \
    digits=5 cols=80 pivrel=1e-3
tran tran stop=80n errpreset=conservative
save WWL RWL BL BLB I0.Q I0.Qbar RBL PRE
